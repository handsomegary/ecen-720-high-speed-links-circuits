// Actual filled fulltop with native REDUCED effective floating capacitance approximation; no ALL-fidelity qualification.
simulator lang=spectre
global 0 VSS
include "@pdk_28nm_root@/models/spectre/toplevel.scs" section=tt
simulator lang=spice
.include "core.dist"
simulator lang=spectre
VG (VSS 0) vsource dc=0
VDD (vdd 0) vsource dc=.9
VCM (vcm 0) vsource dc=.472122668
VIN (stim 0) vsource dc=0 mag=1 type=pwl wave=[0 0 2.0000000000000001e-09 0 2.0025000000000001e-09 0.0050000000000000001 2.0975000000000003e-09 0.0050000000000000001 2.1025000000000001e-09 0.0050000000000000001 2.1975000000000003e-09 0.0050000000000000001 2.2025000000000002e-09 0.0050000000000000001 2.2975e-09 0.0050000000000000001 2.3024999999999999e-09 0.0050000000000000001 2.3975e-09 0.0050000000000000001 2.4024999999999999e-09 0.0050000000000000001 2.4975000000000001e-09 0.0050000000000000001 2.5025e-09 0.0050000000000000001 2.5975000000000002e-09 0.0050000000000000001 2.6025000000000001e-09 0.0050000000000000001 2.6975000000000002e-09 0.0050000000000000001 2.7025000000000001e-09 -0.0050000000000000001 2.7975000000000003e-09 -0.0050000000000000001 2.8025000000000002e-09 -0.0050000000000000001 2.8975000000000004e-09 -0.0050000000000000001 2.9025000000000003e-09 -0.0050000000000000001 2.9975000000000005e-09 -0.0050000000000000001 3.0025000000000003e-09 -0.0050000000000000001 3.0975000000000005e-09 -0.0050000000000000001 3.1025000000000004e-09 -0.0050000000000000001 3.1975000000000002e-09 -0.0050000000000000001 3.2025000000000001e-09 -0.0050000000000000001 3.2975000000000002e-09 -0.0050000000000000001 3.3025000000000001e-09 0.0050000000000000001 3.3975000000000003e-09 0.0050000000000000001 3.4025000000000002e-09 -0.0050000000000000001 3.4975e-09 -0.0050000000000000001 3.5024999999999998e-09 -0.0050000000000000001 3.5975e-09 -0.0050000000000000001 3.6024999999999999e-09 -0.0050000000000000001 3.6975000000000001e-09 -0.0050000000000000001 3.7025e-09 -0.0050000000000000001 3.7974999999999998e-09 -0.0050000000000000001 3.8025000000000005e-09 -0.0050000000000000001 3.8974999999999998e-09 -0.0050000000000000001 3.9025000000000005e-09 0.0050000000000000001 3.9974999999999999e-09 0.0050000000000000001 4.0025000000000006e-09 0.0050000000000000001 4.0975e-09 0.0050000000000000001 4.1025000000000007e-09 -0.0050000000000000001 4.1975e-09 -0.0050000000000000001 4.2025000000000007e-09 -0.0050000000000000001 4.2975000000000001e-09 -0.0050000000000000001 4.3025000000000008e-09 -0.0050000000000000001 4.3974999999999993e-09 -0.0050000000000000001 4.4025e-09 -0.0050000000000000001 4.4975000000000002e-09 -0.0050000000000000001 4.5025000000000009e-09 0.0050000000000000001 4.5974999999999995e-09 0.0050000000000000001 4.6025000000000002e-09 -0.0050000000000000001 4.6975000000000004e-09 -0.0050000000000000001 4.7025000000000011e-09 0.0050000000000000001 4.7974999999999996e-09 0.0050000000000000001 4.8025000000000003e-09 -0.0050000000000000001 4.8974999999999997e-09 -0.0050000000000000001 4.9025000000000004e-09 -0.0050000000000000001 4.9974999999999998e-09 -0.0050000000000000001 5.0025000000000005e-09 -0.0050000000000000001 5.0974999999999998e-09 -0.0050000000000000001 5.1025000000000005e-09 0.0050000000000000001 5.1974999999999999e-09 0.0050000000000000001 5.2025000000000006e-09 0.0050000000000000001 5.2975e-09 0.0050000000000000001 5.3025000000000007e-09 0.0050000000000000001 5.3975e-09 0.0050000000000000001 5.4025000000000007e-09 0.0050000000000000001 5.4975000000000001e-09 0.0050000000000000001 5.5025000000000008e-09 -0.0050000000000000001 5.5975000000000002e-09 -0.0050000000000000001 5.6025000000000009e-09 -0.0050000000000000001 5.6974999999999994e-09 -0.0050000000000000001 5.7025000000000001e-09 0.0050000000000000001 5.7975000000000003e-09 0.0050000000000000001 5.802500000000001e-09 -0.0050000000000000001 5.8974999999999995e-09 -0.0050000000000000001 5.9025000000000002e-09 -0.0050000000000000001 5.9975000000000004e-09 -0.0050000000000000001 6.0025000000000011e-09 -0.0050000000000000001 6.0974999999999997e-09 -0.0050000000000000001 6.1025000000000004e-09 0.0050000000000000001 6.1975000000000006e-09 0.0050000000000000001 6.2025000000000013e-09 -0.0050000000000000001 6.2974999999999998e-09 -0.0050000000000000001 6.3025000000000005e-09 0.0050000000000000001 6.3975000000000007e-09 0.0050000000000000001 6.4025000000000014e-09 0.0050000000000000001 6.4974999999999999e-09 0.0050000000000000001 6.5025000000000007e-09 -0.0050000000000000001 6.5974999999999992e-09 -0.0050000000000000001 6.6024999999999999e-09 -0.0050000000000000001 6.6975000000000001e-09 -0.0050000000000000001 6.7025000000000008e-09 0.0050000000000000001 6.7974999999999993e-09 0.0050000000000000001 6.8025e-09 0.0050000000000000001 6.8975000000000002e-09 0.0050000000000000001 6.9025000000000009e-09 0.0050000000000000001 6.9974999999999995e-09 0.0050000000000000001 7.0025000000000002e-09 -0.0050000000000000001 7.0975000000000004e-09 -0.0050000000000000001 7.1025000000000011e-09 0.0050000000000000001 7.1974999999999996e-09 0.0050000000000000001 7.2025000000000003e-09 -0.0050000000000000001 7.2975000000000005e-09 -0.0050000000000000001 7.3025000000000012e-09 0.0050000000000000001 7.3974999999999997e-09 0.0050000000000000001 7.4025000000000004e-09 -0.0050000000000000001 7.4975000000000015e-09 -0.0050000000000000001 7.5025000000000005e-09 -0.0050000000000000001 7.5975000000000007e-09 -0.0050000000000000001 7.6024999999999998e-09 0.0050000000000000001 7.6975000000000016e-09 0.0050000000000000001 7.7025000000000006e-09 0.0050000000000000001 7.7975000000000008e-09 0.0050000000000000001 7.8024999999999999e-09 0.0050000000000000001 7.8975000000000001e-09 0.0050000000000000001 7.9024999999999991e-09 0.0050000000000000001 7.997500000000001e-09 0.0050000000000000001 8.0025e-09 0.0050000000000000001 8.0975000000000002e-09 0.0050000000000000001 8.1024999999999993e-09 -0.0050000000000000001 8.1975000000000011e-09 -0.0050000000000000001 8.2025000000000002e-09 0.0050000000000000001 8.2975000000000003e-09 0.0050000000000000001 8.3024999999999994e-09 -0.0050000000000000001 8.3975000000000012e-09 -0.0050000000000000001 8.4025000000000003e-09 -0.0050000000000000001 8.4975000000000005e-09 -0.0050000000000000001 8.5024999999999995e-09 -0.0050000000000000001 8.5975000000000014e-09 -0.0050000000000000001 8.6025000000000004e-09 -0.0050000000000000001 8.6975000000000006e-09 -0.0050000000000000001 8.7024999999999997e-09 0.0050000000000000001 8.7975000000000015e-09 0.0050000000000000001 8.8025000000000006e-09 0.0050000000000000001 8.8975000000000008e-09 0.0050000000000000001 8.9024999999999998e-09 0.0050000000000000001 8.9975000000000017e-09 0.0050000000000000001 9.0025000000000007e-09 -0.0050000000000000001 9.0975000000000009e-09 -0.0050000000000000001 9.1024999999999999e-09 -0.0050000000000000001 9.1975000000000001e-09 -0.0050000000000000001 9.2024999999999992e-09 -0.0050000000000000001 9.297500000000001e-09 -0.0050000000000000001 9.3025000000000001e-09 0.0050000000000000001 9.3975000000000003e-09 0.0050000000000000001 9.4024999999999993e-09 -0.0050000000000000001 9.4975000000000012e-09 -0.0050000000000000001 9.5025000000000002e-09 -0.0050000000000000001 9.5975000000000004e-09 -0.0050000000000000001 9.6024999999999995e-09 0.0050000000000000001 9.6974999999999997e-09 0.0050000000000000001 9.7024999999999987e-09 -0.0050000000000000001 9.7975000000000005e-09 -0.0050000000000000001 9.8024999999999996e-09 -0.0050000000000000001 9.8974999999999998e-09 -0.0050000000000000001 9.9024999999999988e-09 0.0050000000000000001 9.9975000000000007e-09 0.0050000000000000001 1.00025e-08 0.0050000000000000001 1.00975e-08 0.0050000000000000001 1.0102499999999999e-08 -0.0050000000000000001 1.0197500000000001e-08 -0.0050000000000000001 1.02025e-08 0.0050000000000000001 1.02975e-08 0.0050000000000000001 1.0302499999999999e-08 0.0050000000000000001 1.0397500000000001e-08 0.0050000000000000001 1.04025e-08 -0.0050000000000000001 1.04975e-08 -0.0050000000000000001 1.0502499999999999e-08 0.0050000000000000001 1.0597500000000001e-08 0.0050000000000000001 1.06025e-08 -0.0050000000000000001 1.06975e-08 -0.0050000000000000001 1.0702499999999999e-08 0.0050000000000000001 1.0797500000000001e-08 0.0050000000000000001 1.08025e-08 0.0050000000000000001 1.08975e-08 0.0050000000000000001 1.09025e-08 -0.0050000000000000001 1.09975e-08 -0.0050000000000000001 1.1002499999999999e-08 0.0050000000000000001 1.1097500000000001e-08 0.0050000000000000001 1.11025e-08 0.0050000000000000001 1.11975e-08 0.0050000000000000001 1.1202499999999999e-08 0.0050000000000000001 1.1297500000000001e-08 0.0050000000000000001 1.13025e-08 0.0050000000000000001 1.13975e-08 0.0050000000000000001 1.1402499999999999e-08 -0.0050000000000000001 1.1497500000000001e-08 -0.0050000000000000001 1.15025e-08 0.0050000000000000001 1.15975e-08 0.0050000000000000001 1.1602499999999999e-08 0.0050000000000000001 1.1697500000000001e-08 0.0050000000000000001 1.17025e-08 -0.0050000000000000001 1.17975e-08 -0.0050000000000000001 1.1802499999999999e-08 -0.0050000000000000001 1.1897500000000001e-08 -0.0050000000000000001 1.19025e-08 -0.0050000000000000001 1.19975e-08 -0.0050000000000000001 1.2002499999999999e-08 0.0050000000000000001 1.2097500000000001e-08 0.0050000000000000001 1.21025e-08 0.0050000000000000001 1.2197500000000001e-08 0.0050000000000000001 1.22025e-08 -0.0050000000000000001 1.22975e-08 -0.0050000000000000001 1.2302499999999999e-08 0.0050000000000000001 1.2397500000000001e-08 0.0050000000000000001 1.24025e-08 -0.0050000000000000001 1.24975e-08 -0.0050000000000000001 1.2502499999999999e-08 -0.0050000000000000001 1.2597500000000001e-08 -0.0050000000000000001 1.26025e-08 0.0050000000000000001 1.26975e-08 0.0050000000000000001 1.2702499999999999e-08 -0.0050000000000000001 1.2797500000000001e-08 -0.0050000000000000001 1.28025e-08 0.0050000000000000001 1.28975e-08 0.0050000000000000001 1.2902499999999999e-08 0.0050000000000000001 1.2997500000000001e-08 0.0050000000000000001 1.30025e-08 0.0050000000000000001 1.30975e-08 0.0050000000000000001 1.3102499999999999e-08 -0.0050000000000000001 1.3197500000000001e-08 -0.0050000000000000001 1.32025e-08 0.0050000000000000001 1.32975e-08 0.0050000000000000001 1.33025e-08 0.0050000000000000001 1.3397500000000001e-08 0.0050000000000000001 1.34025e-08 0.0050000000000000001 1.3497500000000001e-08 0.0050000000000000001 1.35025e-08 -0.0050000000000000001 1.35975e-08 -0.0050000000000000001 1.3602499999999999e-08 -0.0050000000000000001 1.3697500000000001e-08 -0.0050000000000000001 1.37025e-08 0.0050000000000000001 1.37975e-08 0.0050000000000000001 1.3802499999999999e-08 0.0050000000000000001 1.3897500000000001e-08 0.0050000000000000001 1.39025e-08 -0.0050000000000000001 1.39975e-08 -0.0050000000000000001 1.4002499999999999e-08 -0.0050000000000000001 1.4097500000000001e-08 -0.0050000000000000001 1.41025e-08 0.0050000000000000001 1.41975e-08 0.0050000000000000001 1.4202499999999999e-08 -0.0050000000000000001 1.4297500000000001e-08 -0.0050000000000000001 1.43025e-08 0.0050000000000000001 1.43975e-08 0.0050000000000000001 1.4402499999999999e-08 -0.0050000000000000001 1.4497500000000001e-08 -0.0050000000000000001 1.45025e-08 0.0050000000000000001 1.4597500000000001e-08 0.0050000000000000001 1.46025e-08 -0.0050000000000000001 1.4700000000000001e-08 -0.0050000000000000001 1.47025e-08 0 1.6700000000000001e-08 0]
EP (drivep vcm stim 0) vcvs gain=.5
EN (driven vcm stim 0) vcvs gain=-.5
RSP (drivep srcp) resistor r=25
RSN (driven srcn) resistor r=25
CINP (srcp inp) capacitor c=200p
CINN (srcn inn) capacitor c=200p
XDUT (vdd VSS inp outp inn outn) la_r6_full_fill_110822
CLOADP (outp 0) capacitor c=20f
CLOADN (outn 0) capacitor c=20f
opts options temp=27 reltol=1e-5 vabstol=1e-8 iabstol=1e-12 gmin=1e-15 rabsshort=0 preserve_inst=all savefilter=none
saveOpt options save=selected currents=selected
save outp outn inp inn srcp srcn stim vcm vdd VDD:p
dcOp dc
tran tran stop=1.6700000000000001e-08 maxstep=2p
